ADE simulation setup
Corners:
  model folders: $SMOS10HV_SPICE_ROOT/amsmodels/spectre
  typ: smos10hv_corner_topinclude.scs[typ]
  wcs: smos10hv_corner_topinclude.scs[wcs]
  bcs: smos10hv_corner_topinclude.scs[bcs]
  wnhp: smos10hv_corner_topinclude.scs[wnhp]
  wphn: smos10hv_corner_topinclude.scs[wphn]
  bpln: smos10hv_corner_topinclude.scs[bpln]
  bnlp: smos10hv_corner_topinclude.scs[bnlp]
  case (off): smos10hv_corner_topinclude.scs[case]
  mc_ade (off): smos10hv_corner_topinclude.scs[mc_ade]
