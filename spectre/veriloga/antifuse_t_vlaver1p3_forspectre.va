`include "discipline.h"
`include "constants.h"
`define starttime 0

module antifuse_t_vla(wr,s);
     inout wr,s;
          electrical wr,s;

	 parameter real vprogramming = 7.499 from[1.0:9.0]; // Vdw >=7.5V, the antifuse will be burn;
	 parameter real vhot = 4.0 from[3.0:7.0]; // after blown, V >= vhot antifuse is hot state.
	 parameter real vcold = 5.0e-3 from[2.0e-3:1.0e-2]; //in cold state, reading current=1uA, r=5K, vcold=5e-3V.
         //  parameter real ron = 5000.0 from[1.0:20000.0]; // resistance of antifuse after blown and in cold state;
       	//  parameter real roff = 1.5e+13 from[0.1e+13:6.5e+13]; // resistance of antifuse at initial state;
        parameter real gcold = 2.0e-4 from[5e-5:7e-2]; // conductance of antifuse after blown and in cold state;
        parameter real ghot = 1.0e-3 from[0.7e-3:1.3e-3];// conductance of antifuse after blown and in hot state;
        parameter real ginitial = 6.7e-14 from[1.5e-14:1.0e-12]; // conductance  of antifuse before blown;
      //  parameter real rpartial = 100.0e+3 from[90.0e+3:110.0e+3]; // resistance that the current flows while blowing.
        parameter real thot = 0.9e-3 from[1.0e-7:1.0e-2]; // time during in hot region;
        parameter integer blownid = 0 from [0:1];  //blownid=0 is unprogrammed state, blownid=1 is programmed state.
        parameter real num = 1.0;

     real gantifuse;
     real vantifuse;
     integer hotOrCold;
  //   real starttime;
     real endtime;
  //   real fake;

  // burning -> voltage is high enough to program the antifuse
  // blownid -> antifuse has been blow (1 ms @ high voltage)
  // hot -> antifuse is still being stressed during the programing. Antifuse R will be ~1K until voltage is removed (< 2V),then antifuse will relax to 'cold' R ~ 5K.

     analog begin
  //   	fake=0*num;
  //   	starttime=0;
        if( blownid==0 ) // to blow the antifuse.
         gantifuse = (1-blownid)*ginitial+blownid*gcold+0*num;
         vantifuse = V(wr,s);
        if (V(wr,s) >= vprogramming) begin  // bias voltage >= blow threshold voltage, antifuse start to blow.
	   endtime = $abstime;
           hotOrCold=0;      // hotOrCold=0 is in hot region.
           gantifuse=(hotOrCold*gcold+(1-hotOrCold)*ghot);
           vantifuse = vhot;
           if ((endtime-`starttime) >= thot) hotOrCold=1;     // if time >thot, move to cold region.
      end
        if (hotOrCold==1) begin
        gantifuse=(hotOrCold*gcold+(1-hotOrCold)*ghot);
        vantifuse = vcold;
     end

      else if (V(wr,s) < vprogramming) begin // blownid=0 but bias V<vprogramming, antifuse cannot be blown.
         gantifuse = (1-blownid)*ginitial;
         vantifuse = V(wr,s);
       end

     if (blownid==1) begin    // blownid=1, this is reading state, antifuse already blow before.
         gantifuse = (1-blownid)*ginitial+blownid*gcold;
         vantifuse = vcold;
    end

      I(wr,s) <+ vantifuse*gantifuse;

      end
    endmodule
