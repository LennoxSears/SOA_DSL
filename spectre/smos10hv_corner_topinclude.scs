library smos10hv_pb

section always_needed
  include "smos10hv_ade.scs" section=base
  include "smos10hv_ade.scs" section=process_params
  include "smos10hv_ade.scs" section=diode_parasitic
  include "smos10hv_ade.scs" section=substrate_cap
  include "smos10hv_ade.scs" section=no_stat_mis
  include "smos10hv_ade.scs" section=smos10hv_moscap_enable
  include "smos10hv_ade.scs" section=smos10hv_enable_soa
  include "smos10hv_ade.scs" section=smos10hv_enable_sti
  include "smos10hv_ade.scs" section=smos10hv_enable_wpe
  include "smos10hv_ade.scs" section=smos10hv_enable_dte
  include "smos10hv_ade.scs" section=smos10hv_selfheat_disable
  include "smos10hv_ade.scs" section=smos10hv_disable_esdsoa
  include "smos10hv_ade.scs" section=smos10hv_disable_relimo
  include "smos10hv_ade.scs" section=smos10hv_disable_aging
  include "smos10hv_ade.scs" section=smos10hv_res_tc_spread_disable
  include "smos10hv_ade.scs" section=smos10hv_risk_assessment_disable
  include "smos10hv_ade.scs" section=smos10hv_xpart_default
  include "smos10hv_ade.scs" section=smos10hv_bjt_punch_through_enable
  include "smos10hv_ade.scs" section=power_process_params
  include "smos10hv_ade.scs" section=powermosbvdss_default
  include "smos10hv_ade.scs" section=mosfet
  include "smos10hv_ade.scs" section=powermos
  include "smos10hv_ade.scs" section=resistor
  include "smos10hv_ade.scs" section=bjt
  include "smos10hv_ade.scs" section=capacitor
  include "smos10hv_ade.scs" section=diode
  include "smos10hv_ade.scs" section=drsf_zener
endsection

section typ
  include "smos10hv_ade.scs" section=typ_para_process_params
  include "smos10hv_ade.scs" section=typ_thin_mos_process_params
  include "smos10hv_ade.scs" section=typ_thick_mos_process_params
  include "smos10hv_ade.scs" section=typ_powermos_process_params
  include "smos10hv_ade.scs" section=typ_res_process_params
  include "smos10hv_ade.scs" section=typ_bjt_process_params
  include "smos10hv_ade.scs" section=typ_capacitor_process_params
  include "smos10hv_ade.scs" section=typ_drsf_zener_process_params
  include "smos10hv_corner_topinclude.scs" section=always_needed
endsection

section wcs
  include "smos10hv_ade.scs" section=lo_para_process_params
  include "smos10hv_ade.scs" section=wcs_thin_mos_process_params
  include "smos10hv_ade.scs" section=wcs_thick_mos_process_params
  include "smos10hv_ade.scs" section=wcs_powermos_process_params
  include "smos10hv_ade.scs" section=lo_res_process_params
  include "smos10hv_ade.scs" section=wcs_bjt_process_params
  include "smos10hv_ade.scs" section=lo_capacitor_process_params
  include "smos10hv_ade.scs" section=lobv_lovf_drsf_zener_process_params
  include "smos10hv_corner_topinclude.scs" section=always_needed
endsection

section bcs
  include "smos10hv_ade.scs" section=hi_para_process_params
  include "smos10hv_ade.scs" section=bcs_thin_mos_process_params
  include "smos10hv_ade.scs" section=bcs_thick_mos_process_params
  include "smos10hv_ade.scs" section=bcs_powermos_process_params
  include "smos10hv_ade.scs" section=hi_res_process_params
  include "smos10hv_ade.scs" section=bcs_bjt_process_params
  include "smos10hv_ade.scs" section=hi_capacitor_process_params
  include "smos10hv_ade.scs" section=hibv_hivf_drsf_zener_process_params
  include "smos10hv_corner_topinclude.scs" section=always_needed
endsection

section wnhp
  include "smos10hv_ade.scs" section=lo_para_process_params
  include "smos10hv_ade.scs" section=typ_powermos_process_params
  include "smos10hv_ade.scs" section=typ_res_process_params
  include "smos10hv_ade.scs" section=typ_bjt_process_params
  include "smos10hv_ade.scs" section=typ_capacitor_process_params
  include "smos10hv_ade.scs" section=typ_drsf_zener_process_params
  include "smos10hv_ade.scs" section=wnhp_thin_mos_process_params
  include "smos10hv_ade.scs" section=wnhp_thick_mos_process_params
  include "smos10hv_corner_topinclude.scs" section=always_needed
endsection

section wphn
  include "smos10hv_ade.scs" section=lo_para_process_params
  include "smos10hv_ade.scs" section=typ_powermos_process_params
  include "smos10hv_ade.scs" section=typ_res_process_params
  include "smos10hv_ade.scs" section=typ_bjt_process_params
  include "smos10hv_ade.scs" section=typ_capacitor_process_params
  include "smos10hv_ade.scs" section=typ_drsf_zener_process_params
  include "smos10hv_ade.scs" section=wphn_thin_mos_process_params
  include "smos10hv_ade.scs" section=wphn_thick_mos_process_params
  include "smos10hv_corner_topinclude.scs" section=always_needed
endsection

section bpln
  include "smos10hv_ade.scs" section=hi_para_process_params
  include "smos10hv_ade.scs" section=typ_powermos_process_params
  include "smos10hv_ade.scs" section=typ_res_process_params
  include "smos10hv_ade.scs" section=typ_bjt_process_params
  include "smos10hv_ade.scs" section=typ_capacitor_process_params
  include "smos10hv_ade.scs" section=typ_drsf_zener_process_params
  include "smos10hv_ade.scs" section=bpln_thin_mos_process_params
  include "smos10hv_ade.scs" section=bpln_thick_mos_process_params
  include "smos10hv_corner_topinclude.scs" section=always_needed
endsection

section bnlp
  include "smos10hv_ade.scs" section=hi_para_process_params
  include "smos10hv_ade.scs" section=typ_powermos_process_params
  include "smos10hv_ade.scs" section=typ_res_process_params
  include "smos10hv_ade.scs" section=typ_bjt_process_params
  include "smos10hv_ade.scs" section=typ_capacitor_process_params
  include "smos10hv_ade.scs" section=typ_drsf_zener_process_params
  include "smos10hv_ade.scs" section=bnlp_thin_mos_process_params
  include "smos10hv_ade.scs" section=bnlp_thick_mos_process_params
  include "smos10hv_corner_topinclude.scs" section=always_needed
endsection

section case
  include "smos10hv_ade.scs" section=case
  include "smos10hv_ade.scs" section=smos10hv_case_default
  include "smos10hv_ade.scs" section=smos10hv_enable_case_sweep
  include "smos10hv_corner_topinclude.scs" section=always_needed
endsection

section mc_ade
  include "smos10hv_ade.scs" section=mc_thin_mos_process_params
  include "smos10hv_ade.scs" section=mc_thick_mos_process_params
  include "smos10hv_ade.scs" section=mc_res_process_params
  include "smos10hv_ade.scs" section=mc_bjt_process_params
  include "smos10hv_ade.scs" section=mc_capacitor_process_params
  include "smos10hv_ade.scs" section=mc_drsf_zener_process_params
  include "smos10hv_ade.scs" section=mc_powermos_process_params
  include "smos10hv_ade.scs" section=mc_para_process_params
  include "smos10hv_ade.scs" section=base
  include "smos10hv_ade.scs" section=process_params
  include "smos10hv_ade.scs" section=diode_parasitic
  include "smos10hv_ade.scs" section=substrate_cap
  include "smos10hv_ade.scs" section=stat_mis
  include "smos10hv_ade.scs" section=smos10hv_moscap_enable
  include "smos10hv_ade.scs" section=smos10hv_disable_soa
  include "smos10hv_ade.scs" section=smos10hv_enable_sti
  include "smos10hv_ade.scs" section=smos10hv_enable_wpe
  include "smos10hv_ade.scs" section=smos10hv_enable_dte
  include "smos10hv_ade.scs" section=smos10hv_selfheat_disable
  include "smos10hv_ade.scs" section=smos10hv_disable_esdsoa
  include "smos10hv_ade.scs" section=smos10hv_disable_relimo
  include "smos10hv_ade.scs" section=smos10hv_disable_aging
  include "smos10hv_ade.scs" section=smos10hv_res_tc_spread_disable
  include "smos10hv_ade.scs" section=smos10hv_risk_assessment_disable
  include "smos10hv_ade.scs" section=smos10hv_xpart_default
  include "smos10hv_ade.scs" section=smos10hv_bjt_punch_through_enable
  include "smos10hv_ade.scs" section=power_process_params
  include "smos10hv_ade.scs" section=powermosbvdss_default
  include "smos10hv_ade.scs" section=mosfet
  include "smos10hv_ade.scs" section=powermos
  include "smos10hv_ade.scs" section=resistor
  include "smos10hv_ade.scs" section=bjt
  include "smos10hv_ade.scs" section=capacitor
  include "smos10hv_ade.scs" section=diode
  include "smos10hv_ade.scs" section=drsf_zener
endsection

section selfheat
  include "smos10hv_ade.scs" section=base
  include "smos10hv_ade.scs" section=process_params
  include "smos10hv_ade.scs" section=diode_parasitic
  include "smos10hv_ade.scs" section=substrate_cap
  include "smos10hv_ade.scs" section=no_stat_mis
  include "smos10hv_ade.scs" section=smos10hv_moscap_enable
  include "smos10hv_ade.scs" section=smos10hv_disable_soa
  include "smos10hv_ade.scs" section=smos10hv_enable_sti
  include "smos10hv_ade.scs" section=smos10hv_enable_wpe
  include "smos10hv_ade.scs" section=smos10hv_enable_dte
  include "smos10hv_ade.scs" section=smos10hv_selfheat_enable
  include "smos10hv_ade.scs" section=smos10hv_disable_esdsoa
  include "smos10hv_ade.scs" section=smos10hv_disable_relimo
  include "smos10hv_ade.scs" section=smos10hv_disable_aging
  include "smos10hv_ade.scs" section=smos10hv_res_tc_spread_disable
  include "smos10hv_ade.scs" section=smos10hv_risk_assessment_disable
  include "smos10hv_ade.scs" section=smos10hv_xpart_default
  include "smos10hv_ade.scs" section=smos10hv_bjt_punch_through_enable
  include "smos10hv_ade.scs" section=power_process_params
  include "smos10hv_ade.scs" section=powermosbvdss_default
  include "smos10hv_ade.scs" section=mosfet
  include "smos10hv_ade.scs" section=powermos
  include "smos10hv_ade.scs" section=resistor
  include "smos10hv_ade.scs" section=bjt
  include "smos10hv_ade.scs" section=capacitor
  include "smos10hv_ade.scs" section=diode
  include "smos10hv_ade.scs" section=drsf_zener
endsection

endlibrary
