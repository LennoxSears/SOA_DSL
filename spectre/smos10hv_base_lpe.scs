*-*************************************************************************************
*-*              (C) COPYRIGHT 2016, NXP, ALL RIGHTS RESERVED
*-*                      NXP CONFIDENTIAL PROPRIETARY
*-*                              INTERNAL USE ONLY
*-*************************************************************************************
*-* $Source: /ds/vault/14824/server_vault/Projects/spice_smos10hv/NXP_SMOS10HV_SPICE/amsmodels/spectre/smos10hv_base_lpe.scs.rca $
*-* $Revision: 1.5 $
*-* $Date: Wed Mar  8 15:07:23 2023 $
*-* $Author: nxa23194 $
*-*
*-* (C) Copyright 2016, NXP, all rights reserved.
*-*
*-* Description: file for LPE support
*-*
*-*************************************************************************************
*-*
*-* $Log: smos10hv_base_lpe.scs.rca $
*-*
*-*  Revision: 1.5 Wed Mar  8 15:07:23 2023 nxa23194
*-*  *** empty comment string ***
*-*
*-*  Revision: 1.4 Tue Dec  1 18:11:09 2020 nxa23194
*-*  *** empty comment string ***
*-*
*-*  Revision: 1.1 Mon Apr  8 09:59:46 2019 nxa11814
*-*  -o- Initial version.
*-*
*-*  Revision: 1.3 Mon Oct 15 10:21:17 2018 nxa11814
*-*  -o- models V3I_0;
*-*
*-*  Revision: 1.2 Wed May 18 09:42:09 2016 ra7409
*-*  fixed bug
*-*
*-*  Revision: 1.1 Wed May 18 09:14:52 2016 ra7409
*-*  added base_lpe lib for TKT295706 support
*-*
*-*
*-*
*-*************************************************************************************

simulator lang=spectre

library models_lpe
section base_lpe

global 0 vsub

RVSUBA (vsub vsub!) resistor r=1.0m
RVSUBB (vsub vsub!) resistor r=1.0m

endsection base_lpe
endlibrary models_lpe
