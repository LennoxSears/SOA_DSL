simulator lang=spectre
// Generated from SOA DSL
// Process: SMOS10HV
// Version: 1.0
// Date: 2025-12-08

section base

parameters
+ global_tmin      = 0
+ global_tdelay    = 0
+ global_vballmsg  = 1.0
+ global_stop      = 0
+ tcelsius0        = 273.15
+ tref_soa         = 25

// duration limits
+ tmaxfrac0 = 0
+ tmaxfrac1 = 0.01
+ tmaxfrac2 = 0.1
+ tmaxfrac3 = -1

// SOA limits
+ ap_fwd_ref = 0.9943
+ ap_fwd_T = -0.0006
+ ap_fwd = ap_fwd_ref + ap_fwd_T * (temp - tref_soa)
+ ap_no_check = 999.0
+ ap_gc_lv = 1.65
+ ap_gc_hv = 5.5
+ ap_fwd_hv = 1.2
+ ap_gc_lv_oxrisk = 1.32
+ ap_gc_hv_oxrisk = 4.4
+ dtmax_rm = 5
+ theat = 1e-07

endsection base

section bandgap_ref_soa
// Rule: Reference Voltage Range
// Bandgap reference output must stay within range
model ovcheck_Reference_Voltage_Range ovcheck
+ tmin=global_tmin tdelay=global_tdelay
+ vballmsg=global_vballmsg stop=global_stop
+ tmaxfrac=tmaxfrac0
+ vlow=1.15 vhigh=1.25
+ branch1="v[out]"

endsection bandgap_ref_soa

section cap_low_soa
// Rule: Low Voltage Capacitor
// Terminal-well voltage for low-voltage capacitor
model ovcheck_Low_Voltage_Capacitor ovcheck
+ tmin=global_tmin tdelay=global_tdelay
+ vballmsg=global_vballmsg stop=global_stop
+ tmaxfrac=tmaxfrac0
+ vlow=-1.65 vhigh=1.65
+ branch1="v[t,nw]"

// Rule: Capacitor Substrate Check
// Well-substrate voltage for capacitor
model ovcheck_Capacitor_Substrate_Check ovcheck
+ tmin=global_tmin tdelay=global_tdelay
+ vballmsg=global_vballmsg stop=global_stop
+ tmaxfrac=tmaxfrac0
+ vlow=-70.0 vhigh=120.0
+ branch1="v[nw,sub]"

endsection cap_low_soa

section cap_mid_soa
// Rule: Mid Voltage Capacitor
// Terminal-well voltage for mid-voltage capacitor
model ovcheck_Mid_Voltage_Capacitor ovcheck
+ tmin=global_tmin tdelay=global_tdelay
+ vballmsg=global_vballmsg stop=global_stop
+ tmaxfrac=tmaxfrac0
+ vlow=-5.5 vhigh=5.5
+ branch1="v[t,nw]"

endsection cap_mid_soa

section diode_n_soa
// Rule: N-type Diode Substrate
// N-region to substrate voltage
model ovcheck_N-type_Diode_Substrate ovcheck
+ tmin=global_tmin tdelay=global_tdelay
+ vballmsg=global_vballmsg stop=global_stop
+ tmaxfrac=tmaxfrac0
+ vlow=-70.0 vhigh=120.0
+ branch1="v[n,sub]"

endsection diode_n_soa

section diode_p_soa
// Rule: P-type Diode Substrate
// P-region to substrate voltage
model ovcheck_P-type_Diode_Substrate ovcheck
+ tmin=global_tmin tdelay=global_tdelay
+ vballmsg=global_vballmsg stop=global_stop
+ tmaxfrac=tmaxfrac0
+ vlow=-70.0 vhigh=120.0
+ branch1="v[p,sub]"

endsection diode_p_soa

section dz5_soa
// Rule: Diode Temperature Dependent Voltage
// Forward voltage limit decreases with temperature
model ovcheck_Diode_Temperature_Dependent_Voltage ovcheck
+ tmin=global_tmin tdelay=global_tdelay
+ vballmsg=global_vballmsg stop=global_stop
+ tmaxfrac=tmaxfrac0
+ vlow=-999.0 vhigh=0.9943 - 0.0006*(T - 25)
+ branch1="v[p,n]"

// Rule: Diode Multi-Pin with Min Function
// Reverse voltage limited by substrate potential
model ovcheck_Diode_Multi-Pin_with_Min_Function ovcheck
+ tmin=global_tmin tdelay=global_tdelay
+ vballmsg=global_vballmsg stop=global_stop
+ tmaxfrac=tmaxfrac0
+ vlow=min(90, 90 + v[p] - v[sub]) vhigh=999.0
+ branch1="v[n,p]"

endsection dz5_soa

section nmos90_10hv_soa
// Rule: HV Device Substrate Dependent
// Drain-substrate voltage with substrate tracking
model ovcheck_HV_Device_Substrate_Dependent ovcheck
+ tmin=global_tmin tdelay=global_tdelay
+ vballmsg=global_vballmsg stop=global_stop
+ tmaxfrac=tmaxfrac0
+ vlow=-999.0 vhigh=max(70, min(120, 90 + v[sub]))
+ branch1="v[d,sub]"

// Rule: NMOS 90V Multi-Branch
// All voltage limits for 90V NMOS
model ovcheck_1 ovcheck6
+ tmin=global_tmin tdelay=global_tdelay
+ vballmsg=global_vballmsg stop=global_stop
+ tmaxfrac=tmaxfrac0
+ vlow1=-ap_gc_hv vhigh1=ap_gc_hv
+ branch1="V(g,b)"
+ vlow2=-ap_gc_hv vhigh2=ap_gc_hv
+ branch2="V(g,s)"
+ vlow3=-90 vhigh3=ap_gc_hv
+ branch3="V(g,d)"
+ vlow4=-ap_fwd_hv vhigh4=ap_gc_hv
+ branch4="V(s,b)"
+ vlow5=-ap_fwd_hv vhigh5=90
+ branch5="V(d,b)"
+ vlow6=-ap_gc_hv vhigh6=90
+ branch6="V(d,s)"

// Rule: NMOS 90V Oxide Risk
// Gate oxide risk assessment for 90V NMOS
model ovcheck_1 ovcheck6
+ tmin=global_tmin tdelay=global_tdelay
+ vballmsg=global_vballmsg stop=global_stop
+ tmaxfrac=tmaxfrac0
+ vlow1=-ap_gc_hv_oxrisk vhigh1=ap_gc_hv_oxrisk
+ branch1="V(g,b)"
+ vlow2=-ap_gc_hv_oxrisk vhigh2=ap_gc_hv_oxrisk
+ branch2="V(g,s)"
+ vlow3=-ap_gc_hv_oxrisk vhigh3=ap_gc_hv_oxrisk
+ branch3="V(g,d)"

endsection nmos90_10hv_soa

section nmos_5v_soa
// Rule: NMOS Gate Oxide Conditional
// Gate-source voltage reduced at low temperature
model ovcheck_NMOS_Gate_Oxide_Conditional ovcheck
+ tmin=global_tmin tdelay=global_tdelay
+ vballmsg=global_vballmsg stop=global_stop
+ tmaxfrac=tmaxfrac0
+ vlow=-999.0 vhigh=if T < 0 then 5.0 else 5.5
+ branch1="v[g,s]"

endsection nmos_5v_soa

section nmos_core_soa
// Rule: NMOS Core VDS Simple Limit
// Drain-source voltage must not exceed 1.65V
model ovcheck_NMOS_Core_VDS_Simple_Limit ovcheck
+ tmin=global_tmin tdelay=global_tdelay
+ vballmsg=global_vballmsg stop=global_stop
+ tmaxfrac=tmaxfrac0
+ vlow=-999.0 vhigh=1.65
+ branch1="v[d,s]"

// Rule: Junction Temperature Dependent
// Source-bulk junction forward bias limit
model ovcheck_Junction_Temperature_Dependent ovcheck
+ tmin=global_tmin tdelay=global_tdelay
+ vballmsg=global_vballmsg stop=global_stop
+ tmaxfrac=tmaxfrac0
+ vlow=ap_fwd_ref + ap_fwd_T * (T - tref_soa) vhigh=999.0
+ branch1="v[s,b]"

// Rule: NMOS Core Multi-Level VDS
// Drain-source voltage with time-dependent relaxation
model ovcheck_0 ovcheck
+ tmin=global_tmin tdelay=global_tdelay
+ vballmsg=global_vballmsg stop=global_stop
+ tmaxfrac=tmaxfrac0
+ vlow=-999.0 vhigh=1.65
+ branch1="v[d,s]"

model ovcheck_1 ovcheck
+ tmin=global_tmin tdelay=global_tdelay
+ vballmsg=global_vballmsg stop=global_stop
+ tmaxfrac=tmaxfrac1
+ vlow=-999.0 vhigh=1.84
+ branch1="v[d,s]"

model ovcheck_2 ovcheck
+ tmin=global_tmin tdelay=global_tdelay
+ vballmsg=global_vballmsg stop=global_stop
+ tmaxfrac=tmaxfrac2
+ vlow=-999.0 vhigh=1.71
+ branch1="v[d,s]"

// Rule: NMOS Core State Dependent
// Drain-source voltage depends on device on/off state
model ovcheck_0 ovcheckva_mos2
+ tmin=global_tmin tdelay=global_tdelay
+ vballmsg=global_vballmsg stop=global_stop
+ tmaxfrac=tmaxfrac0
+ vhigh_ds_on=1.84
+ vhigh_ds_off=3.0
+ vhigh_gc=2.07
+ vlow_gc=-2.07
+ param="vth" device=device

// Rule: NMOS Core Oxide Risk
// Gate oxide risk assessment for core NMOS
model ovcheck_1 ovcheck6
+ tmin=global_tmin tdelay=global_tdelay
+ vballmsg=global_vballmsg stop=global_stop
+ tmaxfrac=tmaxfrac0
+ vlow1=-ap_gc_lv_oxrisk vhigh1=ap_gc_lv_oxrisk
+ branch1="V(g,b)"
+ vlow2=-ap_gc_lv_oxrisk vhigh2=ap_gc_lv_oxrisk
+ branch2="V(g,s)"
+ vlow3=-ap_gc_lv_oxrisk vhigh3=ap_gc_lv_oxrisk
+ branch3="V(g,d)"

endsection nmos_core_soa

section npn_b_soa
// Rule: BJT Conditional Voltage Limit
// Collector-emitter voltage reduced at high temperature
model ovcheck_BJT_Conditional_Voltage_Limit ovcheck
+ tmin=global_tmin tdelay=global_tdelay
+ vballmsg=global_vballmsg stop=global_stop
+ tmaxfrac=tmaxfrac0
+ vlow=-999.0 vhigh=if T > 85 then 10.0 else 12.0
+ branch1="v[c,e]"

endsection npn_b_soa

section pmos90_10hv_soa
// Rule: PMOS 90V with HCI/TDDB Check
// 90V PMOS with aging reliability check
model ovcheck_PMOS_90V_with_HCI/TDDB_Check ovcheck
+ tmin=global_tmin tdelay=global_tdelay
+ vballmsg=global_vballmsg stop=global_stop
+ tmaxfrac=tmaxfrac0
+ vlow=-999.0 vhigh=90
+ branch1="v[d,s]"

endsection pmos90_10hv_soa

section pmos_core_soa
// Rule: PMOS Core VDS Simple Limit
// Drain-source voltage must not exceed 2.08V
model ovcheck_PMOS_Core_VDS_Simple_Limit ovcheck
+ tmin=global_tmin tdelay=global_tdelay
+ vballmsg=global_vballmsg stop=global_stop
+ tmaxfrac=tmaxfrac0
+ vlow=-999.0 vhigh=2.08
+ branch1="v[d,s]"

// Rule: PMOS Core Multi-Level VDS
// Drain-source voltage with time-dependent relaxation
model ovcheck_0 ovcheck
+ tmin=global_tmin tdelay=global_tdelay
+ vballmsg=global_vballmsg stop=global_stop
+ tmaxfrac=tmaxfrac0
+ vlow=-999.0 vhigh=1.65
+ branch1="v[d,s]"

model ovcheck_1 ovcheck
+ tmin=global_tmin tdelay=global_tdelay
+ vballmsg=global_vballmsg stop=global_stop
+ tmaxfrac=tmaxfrac1
+ vlow=-999.0 vhigh=1.89
+ branch1="v[d,s]"

model ovcheck_2 ovcheck
+ tmin=global_tmin tdelay=global_tdelay
+ vballmsg=global_vballmsg stop=global_stop
+ tmaxfrac=tmaxfrac2
+ vlow=-999.0 vhigh=2.07
+ branch1="v[d,s]"

// Rule: PMOS Core State Dependent
// Drain-source voltage depends on device on/off state
model ovcheck_0 ovcheckva_mos2
+ tmin=global_tmin tdelay=global_tdelay
+ vballmsg=global_vballmsg stop=global_stop
+ tmaxfrac=tmaxfrac0
+ vhigh_ds_on=2.08
+ vhigh_ds_off=3.0
+ vhigh_gc=1.95
+ vlow_gc=-1.95
+ param="vth" device=device

endsection pmos_core_soa

section poly_10hv_soa
// Rule: Poly Resistor Current Width Dependency
// Maximum current scales with width and number of parallel segments
model ovcheck_Poly_Resistor_Current_Width_Dependency ovcheck
+ tmin=global_tmin tdelay=global_tdelay
+ vballmsg=global_vballmsg stop=global_stop
+ tmaxfrac=tmaxfrac0
+ vlow=-999.0 vhigh=999.0
+ branch1="i[poly_10hv]"

endsection poly_10hv_soa

section rm1_10hv_soa
// Rule: Metal Resistor DC Current
// DC current density limit for metal-1 resistor
model ovcheck_Metal_Resistor_DC_Current ovcheck
+ tmin=global_tmin tdelay=global_tdelay
+ vballmsg=global_vballmsg stop=global_stop
+ tmaxfrac=tmaxfrac0
+ vlow=-999.0 vhigh=999.0
+ branch1="i[rm1_10hv]"

// Rule: Metal-1 Resistor with Self-Heating
// Metal-1 resistor with DC, peak, and RMS current limits
model ovcheck_Metal-1_Resistor_with_Self-Heating ovcheck
+ tmin=global_tmin tdelay=global_tdelay
+ vballmsg=global_vballmsg stop=global_stop
+ tmaxfrac=tmaxfrac0

endsection rm1_10hv_soa

section temp_sensor_soa
// Rule: Temperature Sensor Range
// Temperature sensor output range
model ovcheck_Temperature_Sensor_Range ovcheck
+ tmin=global_tmin tdelay=global_tdelay
+ vballmsg=global_vballmsg stop=global_stop
+ tmaxfrac=tmaxfrac0
+ vlow=0.5 + 0.002*T vhigh=0.7 + 0.002*T
+ branch1="v[out]"

endsection temp_sensor_soa
